** sch_path: /foss/designs/pad-ring-ihp/xschem/chip_top.sch
**.subckt chip_top
sg13g2_IOPad_dout[0]sg13g2_IOPad_io_dout VSS VDD IOVSS IOVDD dout_o[0] dout_PAD[0] sg13g2_IOPadOut30mA
sg13g2_IOPad_dout[1]sg13g2_IOPad_io_dout VSS VDD IOVSS IOVDD dout_o[1] dout_PAD[1] sg13g2_IOPadOut30mA
sg13g2_IOPad_dout[2]sg13g2_IOPad_io_dout VSS VDD IOVSS IOVDD dout_o[2] dout_PAD[2] sg13g2_IOPadOut30mA
sg13g2_IOPad_dout[3]sg13g2_IOPad_io_dout VSS VDD IOVSS IOVDD dout_o[3] dout_PAD[3] sg13g2_IOPadOut30mA
sg13g2_IOPad_dout[4]sg13g2_IOPad_io_dout VSS VDD IOVSS IOVDD dout_o[4] dout_PAD[4] sg13g2_IOPadOut30mA
sg13g2_IOPad_dout[5]sg13g2_IOPad_io_dout VSS VDD IOVSS IOVDD dout_o[5] dout_PAD[5] sg13g2_IOPadOut30mA
sg13g2_IOPad_dout[6]sg13g2_IOPad_io_dout VSS VDD IOVSS IOVDD dout_o[6] dout_PAD[6] sg13g2_IOPadOut30mA
sg13g2_IOPad_dout[7]sg13g2_IOPad_io_dout VSS VDD IOVSS IOVDD dout_o[7] dout_PAD[7] sg13g2_IOPadOut30mA
sg13g2_IOPad_io_clk VSS VDD IOVSS IOVDD clk_i clk_PAD sg13g2_IOPadIn
sg13g2_IOPad_io_rst VSS VDD IOVSS IOVDD rst_n_i rst_n_PAD sg13g2_IOPadIn
sg13g2_IOPad_din_lo[0]sg13g2_IOPad_io_din VSS VDD IOVSS IOVDD din_i[0] din_lo_PAD[0] sg13g2_IOPadIn
sg13g2_IOPad_din_lo[1]sg13g2_IOPad_io_din VSS VDD IOVSS IOVDD din_i[1] din_lo_PAD[1] sg13g2_IOPadIn
sg13g2_IOPad_din_lo[2]sg13g2_IOPad_io_din VSS VDD IOVSS IOVDD din_i[2] din_lo_PAD[2] sg13g2_IOPadIn
sg13g2_IOPad_din_lo[3]sg13g2_IOPad_io_din VSS VDD IOVSS IOVDD din_i[3] din_lo_PAD[3] sg13g2_IOPadIn
sg13g2_IOPad_din_lo[4]sg13g2_IOPad_io_din VSS VDD IOVSS IOVDD din_i[4] din_lo_PAD[4] sg13g2_IOPadIn
sg13g2_IOPad_din_lo[5]sg13g2_IOPad_io_din VSS VDD IOVSS IOVDD din_i[5] din_lo_PAD[5] sg13g2_IOPadIn
sg13g2_IOPad_iovdd_w VSS VDD IOVSS IOVDD sg13g2_IOPadIOVdd
sg13g2_IOPad_iovss_w VSS VDD IOVSS IOVDD sg13g2_IOPadIOVss
sg13g2_IOPad_din_hi[0]sg13g2_IOPad_io_din VSS VDD IOVSS IOVDD din_i[6] din_hi_PAD[0] sg13g2_IOPadIn
sg13g2_IOPad_din_hi[1]sg13g2_IOPad_io_din VSS VDD IOVSS IOVDD din_i[7] din_hi_PAD[1] sg13g2_IOPadIn
sg13g2_IOPad_io_start VSS VDD IOVSS IOVDD start_i start_PAD sg13g2_IOPadIn
sg13g2_IOPad_io_mode VSS VDD IOVSS IOVDD mode_i mode_PAD sg13g2_IOPadIn
sg13g2_IOPad_vdd_w VSS VDD IOVSS IOVDD sg13g2_IOPadVdd
sg13g2_IOPad_vss_w VSS VDD IOVSS IOVDD sg13g2_IOPadVss
sg13g2_IOPad_iovdd_e VSS VDD IOVSS IOVDD sg13g2_IOPadIOVdd
sg13g2_IOPad_iovss_e VSS VDD IOVSS IOVDD sg13g2_IOPadIOVss
sg13g2_IOPad_io_done VSS VDD IOVSS IOVDD done_o done_PAD sg13g2_IOPadOut30mA
sg13g2_IOPad_io_busy VSS VDD IOVSS IOVDD busy_o busy_PAD sg13g2_IOPadOut30mA
sg13g2_IOPad_io_irq VSS VDD IOVSS IOVDD irq_o irq_PAD sg13g2_IOPadOut30mA
sg13g2_IOPad_io_gpio VSS VDD IOVSS IOVDD gpio_in gpio_out gpio_oe gpio_PAD sg13g2_IOPadInOut30mA
sg13g2_IOPad_vdd_e VSS VDD IOVSS IOVDD sg13g2_IOPadVdd
sg13g2_IOPad_vss_e VSS VDD IOVSS IOVDD sg13g2_IOPadVss
**.ends
.end
